NPN Transistor Operated In Active Mode

** Circuit Description **
Vcc 1 0 DC +10V
Vbb 3 0 DC +4V
Q1 2 3 4 npn_transistor
Rc 1 2 4.7k
Re 4 0 3.3k
* transistor model statement
.model npn_transistor npn (Is=1.8104e-15 Bf=100)
** Analysis Requests **
* calculate DC bias point information
.OP
** Output Requests **
* none required
.end
